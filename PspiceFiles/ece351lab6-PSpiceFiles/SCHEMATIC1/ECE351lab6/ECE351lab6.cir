** Profile: "SCHEMATIC1-ECE351lab6"  [ C:\Cadence\Pspice Work\ece351lab6-PSpiceFiles\SCHEMATIC1\ECE351lab6.sim ]

** Creating circuit file "ECE351lab6.cir"
** WARNING: THIS AUTOMATICALLY GENERATED FILE MAY BE OVERWRITTEN BY SUBSEQUENT SIMULATIONS

*Libraries:
* Profile Libraries :
* Local Libraries :
* From [PSPICE NETLIST] section of C:\SPB_Data\cdssetup\OrCAD_PSpice\17.2.0\PSpice.ini file:
.lib "C:\Cadence\RHIT_Libraries\Class.lib"
.lib "nomd.lib"

*Analysis directives:
.AC DEC 10 0.01 100000000
.OPTIONS ADVCONV
.PROBE64 V(alias(*)) I(alias(*)) W(alias(*)) D(alias(*)) NOISE(alias(*))
.INC "..\SCHEMATIC1.net"

.END
