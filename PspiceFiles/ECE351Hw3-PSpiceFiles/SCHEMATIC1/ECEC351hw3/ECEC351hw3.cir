** Profile: "SCHEMATIC1-ECEC351hw3"  [ C:\Cadence\Pspice Work\ECE351Hw3-PSpiceFiles\SCHEMATIC1\ECEC351hw3.sim ]

** Creating circuit file "ECEC351hw3.cir"
** WARNING: THIS AUTOMATICALLY GENERATED FILE MAY BE OVERWRITTEN BY SUBSEQUENT SIMULATIONS

*Libraries:
* Profile Libraries :
* Local Libraries :
.LIB "../../../ece351hw3-pspicefiles/ece351hw3.lib"
* From [PSPICE NETLIST] section of C:\SPB_Data\cdssetup\OrCAD_PSpice\17.2.0\PSpice.ini file:
.lib "nomd.lib"

*Analysis directives:
.OPTIONS ADVCONV
.PROBE64 V(alias(*)) I(alias(*)) W(alias(*)) D(alias(*)) NOISE(alias(*))
.INC "..\SCHEMATIC1.net"

.END
