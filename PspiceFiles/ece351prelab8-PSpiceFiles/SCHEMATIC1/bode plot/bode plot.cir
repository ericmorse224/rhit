** Profile: "SCHEMATIC1-bode plot"  [ C:\Cadence\Pspice Work\ece351prelab8-PSpiceFiles\SCHEMATIC1\bode plot.sim ]

** Creating circuit file "bode plot.cir"
** WARNING: THIS AUTOMATICALLY GENERATED FILE MAY BE OVERWRITTEN BY SUBSEQUENT SIMULATIONS

*Libraries:
* Profile Libraries :
* Local Libraries :
* From [PSPICE NETLIST] section of C:\SPB_Data\cdssetup\OrCAD_PSpice\17.2.0\PSpice.ini file:
.lib "C:\Cadence\RHIT_Libraries\Class.lib"
.lib "nomd.lib"

*Analysis directives:
.AC DEC 10 0.1 10000000
.OPTIONS ADVCONV
.PROBE64 V(alias(*)) I(alias(*)) W(alias(*)) D(alias(*)) NOISE(alias(*))
.INC "..\SCHEMATIC1.net"

.END
