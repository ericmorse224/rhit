** Profile: "SCHEMATIC1-Prelab2"  [ c:\cadence\pspice work\prelab 3-PSpiceFiles\SCHEMATIC1\Prelab2.sim ]

** Creating circuit file "Prelab2.cir"
** WARNING: THIS AUTOMATICALLY GENERATED FILE MAY BE OVERWRITTEN BY SUBSEQUENT SIMULATIONS

*Libraries:
* Profile Libraries :
* Local Libraries :
* From [PSPICE NETLIST] section of C:\SPB_Data\cdssetup\OrCAD_PSpice\17.2.0\PSpice.ini file:
.lib "C:\Cadence\RHIT_Libraries\Class.lib"
.lib "nom.lib"

*Analysis directives:
.TRAN  0 0.05 0 10u
.OPTIONS ADVCONV
.PROBE64 V(alias(*)) I(alias(*)) W(alias(*)) D(alias(*)) NOISE(alias(*))
.INC "..\SCHEMATIC1.net"

.END
