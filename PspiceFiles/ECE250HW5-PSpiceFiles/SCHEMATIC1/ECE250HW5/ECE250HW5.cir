** Profile: "SCHEMATIC1-ECE250HW5"  [ C:\Cadence\Pspice Work\ece250hw5-pspicefiles\schematic1\ECE250HW5.sim ]

** Creating circuit file "ECE250HW5.cir"
** WARNING: THIS AUTOMATICALLY GENERATED FILE MAY BE OVERWRITTEN BY SUBSEQUENT SIMULATIONS

*Libraries:
* Profile Libraries :
* Local Libraries :
.LIB "../../../ece250hw5-pspicefiles/ece250hw5.lib"
* From [PSPICE NETLIST] section of C:\SPB_Data\cdssetup\OrCAD_PSpice\17.2.0\PSpice.ini file:
.lib "nomd.lib"

*Analysis directives:
.DC LIN V_Vin 0 5 1m
.STEP PARAM Vt_val LIST 1 1.25 1.5 2
.OPTIONS ADVCONV
.PROBE64 V(alias(*)) I(alias(*)) W(alias(*)) D(alias(*)) NOISE(alias(*))
.INC "..\SCHEMATIC1.net"

.END
